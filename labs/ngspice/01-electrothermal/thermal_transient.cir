* Two-node motor thermal network, electro-thermal analogy
* node tw = winding rise (K), node tc = case rise (K), gnd = ambient
Ipow 0 tw DC 54.4
Cw   tw 0  12.0
Rwc  tw tc 1.0
Cc   tc 0  100.0
Rca  tc 0  1.5
.tran 0.1 300 uic
.control
run
wrdata /home/claude/portfolio/robotics/robotics-sim-portfolio/labs/ngspice/01-electrothermal/transient.dat v(tw) v(tc)
.endc
.end
